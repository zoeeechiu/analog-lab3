ADE simulation setup
Test ECE4530_2026_MP2_test_bench_1: labs/Lab3_test_bench/schematic, simulator spectre
  Models: /opt/cadence-designkits/gpdk045_v_6_0/gpdk045/../models/spectre/gpdk045.scs[mc]
  Variables: AC_CM = 1; AC_DM = 0; F1 = 1M; F2 = 50M; Vbias = 1.2; vdd = 2.4
  Temperature: 27
  Analysis tran: stop=4u errpreset=conservative maxstep=100p
  Output Hd_dB = dB20((VF("/out_p") - VF("/out_n"))) (unticked)
  Output d_phase = phase((VF("/out_p") - VF("/out_n"))) (unticked)
  Output Vid = (VF("/in") - VF("/ref")) (unticked)
  Output Voutp_ac = dB20(VF("/out_p")) (unticked)
  Output Voutn_ac = dB20(VF("/out_n")) (unticked)
  Output Hc_dB = dB20(((VF("/out_p") + VF("/out_n")) / 2)) (unticked)
  Output c_phase = phase(((VF("/out_p") + VF("/out_n")) / 2)) (unticked)
  Output Voutp_trans = VT("/out_p")
  Output Voutn_trans = VT("/out_n")
  Signals: /out_p, /out_n, /in, /ref
Run mode: Single Run, Sweeps and Corners
