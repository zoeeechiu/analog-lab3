ADE simulation setup
Test ECE4530_2026_MP2_test_bench_1: lab3/lab3_testbench/schematic, simulator spectre
  Models: /opt/cadence-designkits/gpdk045_v_6_0/gpdk045/../models/spectre/gpdk045.scs[mc]
  Variables: r = 2; AC_CM = 1; AC_DM = 1; F1 = 1M; F2 = 50M; Vbias = 1.4; vdd = 2.4
  Temperature: 27
  Analysis ac: start=1k stop=10G dec=1000
  Analysis dc: (saves the operating point)
  Analysis tran: stop=10u errpreset=moderate
  Output AvDMAC = db((vfreq('ac "/out_p") - vfreq('ac "/out_n")))
  Output v /out_p; ac dB20(V) = db(vfreq('ac "/out_p")) (unticked)
  Output v /out_n; ac dB20(V) = db(vfreq('ac "/out_n")) (unticked)
  Output OutP = vfreq('ac "/out_p") (unticked)
  Output OutN = vfreq('ac "/out_n") (unticked)
  Output AvCMAC = dB20(((OutP + OutN) / 2))
  Output FFT = dft((VT("/out_p") - VT("/out_n")) 2e-06 5e-06 8192 "Rectangular" 1 "default" 1.0)
  Output CMRR = (AvDMAC - AvCMAC)
  Output (VT("/out_p") - VT("/out_n"))
  Signals: /out_p, /out_n
Run mode: Single Run, Sweeps and Corners
Setup values for test ECE4530_2026_MP2_test_bench_1: Vbias = 1.2; r = 1:1:10
