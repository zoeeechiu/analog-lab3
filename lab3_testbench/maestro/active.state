ADE simulation setup
Test ECE4530_2026_MP2_test_bench_1: lab3/lab3_testbench/schematic, simulator spectre
  Models: /opt/cadence-designkits/gpdk045_v_6_0/gpdk045/../models/spectre/gpdk045.scs[mc]
  Variables: AC_CM = 0; AC_DM = 1; F1 = 1M; F2 = 50M; Vbias = 1.4; vdd = 2.4
  Temperature: 27
  Analysis ac: start=50k stop=500k dec=20
  Analysis dc: (saves the operating point)
  Analysis tran: stop=10u errpreset=moderate
Run mode: Single Run, Sweeps and Corners
Setup values for test ECE4530_2026_MP2_test_bench_1: AC_CM = 1; Vbias = 1.2; r = 1:1:10
