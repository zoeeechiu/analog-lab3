ADE simulation setup
Test ECE4530_2026_MP2_test_bench_1: lab3/lab3_testbench/schematic, simulator spectre
  Models: /opt/cadence-designkits/gpdk045_v_6_0/gpdk045/../models/spectre/gpdk045.scs[mc]
  Variables: AC_CM = 0; AC_DM = 1; F1 = 1M; F2 = 500M; Vbias = 1.4; vdd = 2.4
  Temperature: 27
  Analysis tran: stop=5u errpreset=moderate
  Analysis dc: (saves the operating point)
  Analysis ac: start=1k stop=1G dec=1000
  Output AvDMAC = db((vfreq('ac "/out_p") - vfreq('ac "/out_n"))) (unticked)
  Output v /out_p; ac dB20(V) = db(vfreq('ac "/out_p")) (unticked)
  Output v /out_n; ac dB20(V) = db(vfreq('ac "/out_n")) (unticked)
  Output OutP = vfreq('ac "/out_p") (unticked)
  Output OutN = vfreq('ac "/out_n") (unticked)
  Output AvCMAC = dB20(((OutP + OutN) / 2)) (unticked)
Run mode: Single Run, Sweeps and Corners
Setup values for test ECE4530_2026_MP2_test_bench_1: AC_CM = 1; F2 = 50M; Vbias = 1.2; r = 1:1:10
