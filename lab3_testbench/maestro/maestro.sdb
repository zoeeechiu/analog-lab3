ADE simulation setup
Run mode: Single Run, Sweeps and Corners
Tests:
  ECE4530_2026_MP2_test_bench_1: lab3/lab3_testbench/schematic, simulator spectre
    Variables: AC_CM = 1; AC_DM = 0; F1 = 1M; F2 = 50M; Vbias = 1.2; vdd = 2.4
